# Ansys Electronics Desktop project, version 2024.1
materials:
  vacuum: permittivity=1

design u142_0711_801 (HFSS, HFSS Hybrid Terminal Network, model units mm)
options: Calculate_Lossy_Dielectrics
geometry:
  u142_0711_801_1 = component(u142_0711_801, 3D_Component_File_Path=/home/ubuntu/Ansoft/ref/u142_0711_801.a3dcomp, N=32)
  center_pin, outer_shell [pec] = part_of(u142_0711_801_1)
  dielectric, port [vacuum] = part_of(u142_0711_801_1)
  cap [pec] = part_of(u142_0711_801_1)
boundaries and excitations:
  u142_0711_801_1_center_pin_T1: Terminal port=u142_0711_801_1_1 Faces=center_pin.face(at (-3, 0, 0)) TerminalResistance=50ohm
  u142_0711_801_1_1: Wave Port Faces=port.face(at (-3, 0, 0)) WavePortType=Terminal NumModes=1
setups:
  AutoSetup1: HfssDriven Frequency=1000000000 MaxDeltaS=0.02 MaximumPasses=6 MinimumPasses=1 MinimumConvergedPasses=1 PercentRefinement=30 BasisOrder=1 PortAccuracy=2 DrivenSolverType="Direct Solver"
  AutoSetup2: HfssDriven Frequency=1000000000 MaxDeltaS=0.02 MaximumPasses=6 MinimumPasses=1 MinimumConvergedPasses=1 PercentRefinement=30 BasisOrder=1 PortAccuracy=2 DrivenSolverType="Direct Solver"
source amplitudes:
  u142_0711_801_1_1:1: 1V 0deg
